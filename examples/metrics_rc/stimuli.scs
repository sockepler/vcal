simulator lang=spectre
VIN (in 0) vsource type=pulse dc=0 val0=0 val1=1 delay=1u rise=1n fall=1n width=20u period=40u
